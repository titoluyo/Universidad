LE2 Realimentacion negativa - S1 ABIERTO (con realimentacion shunt-shunt)
* Entrada: Vg (AC 1V) -> C1 -> R1 ; Ig = I(R1) ; Vo = V(c) ; Rm = V(c)/Ig ; Zi = 1/Ig
Vcc vcc 0 12
Vg  vg 0 DC 0 AC 1
C1  vg n1 10u
R1  n1 b 10k
R2  b 0 10k
RC  vcc c 1k
RE  e 0 100
C3  e 0 10u
R3  b m 5.6k
R4  m c 5.6k
* S1 ABIERTO: el nodo medio m queda flotante (R3+R4 en serie = realimentacion colector-base)
Q1  c b e Q2N2222
.model Q2N2222 NPN(Is=14.34f Xti=3 Eg=1.11 Vaf=74.03 Bf=255.9 Ne=1.307
+ Ise=14.34f Ikf=.2847 Xtb=1.5 Br=6.092 Nc=2 Isc=0 Ikr=0 Rc=1
+ Cjc=7.306p Mjc=.3416 Vjc=.75 Fc=.5 Cje=22.01p Mje=.377 Vje=.75
+ Tr=46.91n Tf=411.1p Itf=.6 Vtf=1.7 Xtf=3 Rb=10)
.op
.ac dec 50 10 200k
.backanno
.end
